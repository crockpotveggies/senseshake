ShakeSense A2 supporting circuit: cf_buck_5p25_0p6_1p2
Vin vin 0 5.25
Vgate gate 0 PULSE(0 1 0 1n 1n 5.714285714285714e-07 9.09090909090909e-07)
Bngate ngate 0 V=1-v(gate)
Shi vin sw gate 0 HI
Slo sw 0 ngate 0 LO
.model HI SW(Ron=0.125 Roff=1e9 Vt=0.5 Vh=0)
.model LO SW(Ron=0.068 Roff=1e9 Vt=0.5 Vh=0)
Lout sw lx 5.639999999999999e-06
Rdcr lx reg 0.0312
Rcap reg cn 0.01
Cout cn 0 26.4u IC=3.3
Rshunt reg module 0.1
Rconnector module chip 0.045
Cchip chip 0 9.6u IC=3.3
Iload chip 0 0.6
.tran 5n 1m UIC
.measure tran vmin MIN v(chip) FROM=800u TO=1m
.measure tran vmax MAX v(chip) FROM=800u TO=1m
.measure tran ripple PP v(chip) FROM=800u TO=1m
.measure tran peak_current MAX i(Lout) FROM=800u TO=1m

.end
