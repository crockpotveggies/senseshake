ShakeSense A2 supporting circuit: power_3p42_0p4_0p05
Vreg source 0 3.42
Rsource source feed 0.05
Ltrace feed board 500n
Rbulk board bulk 0.03
Cbulk bulk 0 8.8e-06
Rlocal board local 0.04
Clocal local 0 1u
Iload board 0 PULSE(0.02 0.20 100u 1u 1u 200u 500u)
.tran 100n 800u
.measure tran vmin MIN v(board) FROM=90u TO=800u
.measure tran vmax MAX v(board) FROM=90u TO=800u

.end
