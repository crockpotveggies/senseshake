ShakeSense Trenz support check: reject_long_power_lead
Vsource src 0 3.267
Rpath src module 0.10
Iload module 0 3
.tran 1u 100u
.measure tran vmodule FIND v(module) AT=99u
.end
