ShakeSense A2 supporting circuit: reset_release
Vsupply vdd 0 PWL(0 0 1m 3.3 0.25 3.3)
Vreset drive 0 PWL(0 1 0.2009 1 0.201 0 0.25 0)
Rpull vdd rst 10000
Cpin rst 0 30p
Sreset rst 0 drive 0 RESET
.model RESET SW(Ron=50 Roff=1e12 Vt=0.5 Vh=0)
.tran 1u 0.22
.measure tran before FIND v(rst) AT=0.19
.measure tran after FIND v(rst) AT=0.202

.end
